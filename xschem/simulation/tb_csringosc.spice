** sch_path: /home/anton/projects/ttgf-algofoogle-analog/xschem/tb_csringosc.sch
**.subckt tb_csringosc
x1 VCC GND vbiasp VIN osc vbiasn osc_raw csringosc
V1 VCC GND 3.3
V2 VIN GND PWL(0us 0.0v 0.1us 0.0v 2us 0.55v 10us 0.55v 15us 0.65v 50us 3.3v 51us 3.3v)
**** begin user architecture code

.include /home/anton/ttsetup@ttgf26a/pdk/gf180mcuD/libs.tech/ngspice/design.ngspice
.lib /home/anton/ttsetup@ttgf26a/pdk/gf180mcuD/libs.tech/ngspice/sm141064.ngspice typical
.lib /home/anton/ttsetup@ttgf26a/pdk/gf180mcuD/libs.tech/ngspice/sm141064.ngspice res_typical
* .lib /home/anton/ttsetup@ttgf26a/pdk/gf180mcuD/libs.tech/ngspice/sm141064.ngspice res_statistical

.control
save i(vcc) i(vin) vin vbiasp vbiasn osc osc_raw
tran 10p 51us
write tb_csringosc.raw
.endc

**** end user architecture code
**.ends

* expanding   symbol:  csringosc.sym # of pins=7
** sym_path: /home/anton/projects/ttgf-algofoogle-analog/xschem/csringosc.sym
** sch_path: /home/anton/projects/ttgf-algofoogle-analog/xschem/csringosc.sch
.subckt csringosc VCC VSS vbiasp vin osc_out vbiasn osc_raw
*.opin osc_out
*.ipin vin
*.iopin VCC
*.iopin VSS
*.opin vbiasp
*.opin vbiasn
*.opin osc_raw
x1 VCC VSS vbiasp osc_raw net2 vbiasn csrostage
x2 VCC VSS vbiasp net2 net3 vbiasn csrostage
x3 VCC VSS vbiasp net3 net4 vbiasn csrostage
x4 VCC VSS vbiasp net4 net5 vbiasn csrostage
x5 VCC VSS vbiasp net5 osc_raw vbiasn csrostage
XMNL vbiasn vbiasn VSS VSS nfet_03v3 L=0.30u W=0.60u nf=1 ad='int((nf+1)/2) * W/nf * 0.18u' as='int((nf+2)/2) * W/nf * 0.18u' pd='2*int((nf+1)/2) * (W/nf + 0.18u)'
+ ps='2*int((nf+2)/2) * (W/nf + 0.18u)' nrd='0.18u / W' nrs='0.18u / W' sa=0 sb=0 sd=0
XMPL vbiasn vbiasp VCC VCC pfet_03v3 L=0.30u W=3.00u nf=1 ad='int((nf+1)/2) * W/nf * 0.18u' as='int((nf+2)/2) * W/nf * 0.18u' pd='2*int((nf+1)/2) * (W/nf + 0.18u)'
+ ps='2*int((nf+2)/2) * (W/nf + 0.18u)' nrd='0.18u / W' nrs='0.18u / W' sa=0 sb=0 sd=0
XMPb vbiasp vbiasp VCC VCC pfet_03v3 L=0.28u W=4.00u nf=1 ad='int((nf+1)/2) * W/nf * 0.18u' as='int((nf+2)/2) * W/nf * 0.18u' pd='2*int((nf+1)/2) * (W/nf + 0.18u)'
+ ps='2*int((nf+2)/2) * (W/nf + 0.18u)' nrd='0.18u / W' nrs='0.18u / W' sa=0 sb=0 sd=0
XMNc vbiasp vin net6 VSS nfet_03v3 L=0.70u W=30.00u nf=6 ad='int((nf+1)/2) * W/nf * 0.18u' as='int((nf+2)/2) * W/nf * 0.18u' pd='2*int((nf+1)/2) * (W/nf + 0.18u)'
+ ps='2*int((nf+2)/2) * (W/nf + 0.18u)' nrd='0.18u / W' nrs='0.18u / W' sa=0 sb=0 sd=0
XR2 net7 net6 VSS ppolyf_u_1k r_width=1u r_length=5u
XR1 VSS net7 VSS ppolyf_u_1k r_width=1u r_length=5u
x6 VCC VSS net1 osc_raw bufinv
x7 VCC VSS osc_out net1 bufinv
.ends

* expanding   symbol:  csrostage.sym # of pins=6
** sym_path: /home/anton/projects/ttgf-algofoogle-analog/xschem/csrostage.sym
** sch_path: /home/anton/projects/ttgf-algofoogle-analog/xschem/csrostage.sch
.subckt csrostage VCC VSS VbiasP A Y VbiasN
*.iopin VCC
*.iopin VSS
*.ipin A
*.opin Y
*.ipin VbiasP
*.ipin VbiasN
XMNi Y A net1 VSS nfet_03v3 L=0.40u W=0.80u nf=1 ad='int((nf+1)/2) * W/nf * 0.18u' as='int((nf+2)/2) * W/nf * 0.18u' pd='2*int((nf+1)/2) * (W/nf + 0.18u)'
+ ps='2*int((nf+2)/2) * (W/nf + 0.18u)' nrd='0.18u / W' nrs='0.18u / W' sa=0 sb=0 sd=0
XMPi Y A net2 VCC pfet_03v3 L=0.40u W=1.60u nf=1 ad='int((nf+1)/2) * W/nf * 0.18u' as='int((nf+2)/2) * W/nf * 0.18u' pd='2*int((nf+1)/2) * (W/nf + 0.18u)'
+ ps='2*int((nf+2)/2) * (W/nf + 0.18u)' nrd='0.18u / W' nrs='0.18u / W' sa=0 sb=0 sd=0
XMPL net2 VbiasP VCC VCC pfet_03v3 L=0.30u W=3.00u nf=1 ad='int((nf+1)/2) * W/nf * 0.18u' as='int((nf+2)/2) * W/nf * 0.18u' pd='2*int((nf+1)/2) * (W/nf + 0.18u)'
+ ps='2*int((nf+2)/2) * (W/nf + 0.18u)' nrd='0.18u / W' nrs='0.18u / W' sa=0 sb=0 sd=0
XMNL net1 VbiasN VSS VSS nfet_03v3 L=0.30u W=0.60u nf=1 ad='int((nf+1)/2) * W/nf * 0.18u' as='int((nf+2)/2) * W/nf * 0.18u' pd='2*int((nf+1)/2) * (W/nf + 0.18u)'
+ ps='2*int((nf+2)/2) * (W/nf + 0.18u)' nrd='0.18u / W' nrs='0.18u / W' sa=0 sb=0 sd=0
.ends

* expanding   symbol:  bufinv.sym # of pins=4
** sym_path: /home/anton/projects/ttgf-algofoogle-analog/xschem/bufinv.sym
** sch_path: /home/anton/projects/ttgf-algofoogle-analog/xschem/bufinv.sch
.subckt bufinv VCC VSS Y A
*.iopin VCC
*.iopin VSS
*.ipin A
*.opin Y
XMNi Y A VSS VSS nfet_03v3 L=0.28u W=0.9u nf=1 ad='int((nf+1)/2) * W/nf * 0.18u' as='int((nf+2)/2) * W/nf * 0.18u' pd='2*int((nf+1)/2) * (W/nf + 0.18u)'
+ ps='2*int((nf+2)/2) * (W/nf + 0.18u)' nrd='0.18u / W' nrs='0.18u / W' sa=0 sb=0 sd=0
XMPi Y A VCC VCC pfet_03v3 L=0.28u W=1.8u nf=1 ad='int((nf+1)/2) * W/nf * 0.18u' as='int((nf+2)/2) * W/nf * 0.18u' pd='2*int((nf+1)/2) * (W/nf + 0.18u)'
+ ps='2*int((nf+2)/2) * (W/nf + 0.18u)' nrd='0.18u / W' nrs='0.18u / W' sa=0 sb=0 sd=0
.ends

.end
