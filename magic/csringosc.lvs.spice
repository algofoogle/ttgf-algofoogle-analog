* NGSPICE file created from csringosc.ext - technology: gf180mcuD

.subckt csrostage VCC VbiasP VSS VbiasN A Y
X0 a_280_590# VbiasP VCC VCC pfet_03v3 ad=0.59348p pd=4.36957u as=1.5p ps=7u w=3u l=0.3u
**devattr s=132000,1640 d=18200,670
X1 Y A a_280_250# VSS nfet_03v3 ad=0.4p pd=2.6u as=0.14857p ps=1.31429u w=0.8u l=0.4u
**devattr s=5200,230 d=16000,520
X2 a_280_250# VbiasN VSS VSS nfet_03v3 ad=0.11143p pd=0.98571u as=0.3p ps=2.2u w=0.6u l=0.3u
**devattr s=26400,680 d=5200,230
X3 Y A a_280_590# VCC pfet_03v3 ad=0.8p pd=4.2u as=0.31652p ps=2.33043u w=1.6u l=0.4u
**devattr s=18200,670 d=32000,840
.ends

.subckt bufinv A Y VSS VCC
X0 Y A VCC VCC pfet_03v3 ad=1.04p pd=5.04u as=1p ps=5u w=2u l=0.28u
**devattr s=80000,1200 d=41600,1008
X1 Y A VSS VSS nfet_03v3 ad=0.52p pd=3.04u as=0.5p ps=3u w=1u l=0.28u
**devattr s=32000,800 d=20800,608
.ends

.subckt nfet_03v3_KT5AJW a_n52_n500# a_296_n592# a_680_n500# a_52_n592# a_n540_n500#
+ a_n436_n592# a_540_n592# a_n192_n592# a_n906_n686# a_436_n500# a_192_n500# a_n768_n500#
+ a_n680_n592# a_n296_n500#
X0 a_436_n500# a_296_n592# a_192_n500# a_n906_n686# nfet_03v3 ad=1.3p pd=5.52u as=1.3p ps=5.52u w=5u l=0.7u
**devattr s=52000,1104 d=52000,1104
X1 a_680_n500# a_540_n592# a_436_n500# a_n906_n686# nfet_03v3 ad=2.2p pd=10.88u as=1.3p ps=5.52u w=5u l=0.7u
**devattr s=52000,1104 d=88000,2176
X2 a_192_n500# a_52_n592# a_n52_n500# a_n906_n686# nfet_03v3 ad=1.3p pd=5.52u as=1.3p ps=5.52u w=5u l=0.7u
**devattr s=52000,1104 d=52000,1104
X3 a_n52_n500# a_n192_n592# a_n296_n500# a_n906_n686# nfet_03v3 ad=1.3p pd=5.52u as=1.3p ps=5.52u w=5u l=0.7u
**devattr s=52000,1104 d=52000,1104
X4 a_n296_n500# a_n436_n592# a_n540_n500# a_n906_n686# nfet_03v3 ad=1.3p pd=5.52u as=1.3p ps=5.52u w=5u l=0.7u
**devattr s=52000,1104 d=52000,1104
X5 a_n540_n500# a_n680_n592# a_n768_n500# a_n906_n686# nfet_03v3 ad=1.3p pd=5.52u as=2.2p ps=10.88u w=5u l=0.7u
**devattr s=88000,2176 d=52000,1104
.ends

.subckt ppolyf_u_1k_ACAPAA a_40_n622# a_40_500# a_n240_n622# a_n240_500# a_n452_n834#
X0 a_40_500# a_40_n622# a_n452_n834# ppolyf_u_1k r_width=1u r_length=5u
X1 a_n240_500# a_n240_n622# a_n452_n834# ppolyf_u_1k r_width=1u r_length=5u
.ends

.subckt csringosc vin VCC VSS vbiasp vbiasn osc_raw osc_out
Xx1 VCC vbiasp VSS vbiasn osc_raw x2/A csrostage
Xx2 VCC vbiasp VSS vbiasn x2/A x3/A csrostage
Xx3 VCC vbiasp VSS vbiasn x3/A x4/A csrostage
Xx4 VCC vbiasp VSS vbiasn x4/A x5/A csrostage
Xx5 VCC vbiasp VSS vbiasn x5/A osc_raw csrostage
Xx6 osc_raw x7/A VSS VCC bufinv
Xx7 x7/A osc_out VSS VCC bufinv
XXMNc vbiasp vin m1_n2680_1360# vin vbiasp vin vin vin VSS vbiasp m1_n2680_1360# m1_n2680_1360#
+ vin m1_n2680_1360# nfet_03v3_KT5AJW
XXR1a2 m1_n2960_210# m1_n2680_1360# m1_n2960_210# VSS VSS ppolyf_u_1k_ACAPAA
X0 VSS vbiasn vbiasn VSS nfet_03v3 ad=0.3p pd=2.2u as=0.3p ps=2.2u w=0.6u l=0.3u
**devattr s=12000,440 d=12000,440
X1 vbiasn vbiasp VCC VCC pfet_03v3 ad=1.5p pd=7u as=1.02p ps=3.96u w=3u l=0.3u
**devattr s=47600,924 d=60000,1400
X2 VCC vbiasp vbiasp VCC pfet_03v3 ad=1.36p pd=5.28u as=2p ps=9u w=4u l=0.28u
**devattr s=80000,1800 d=47600,924
.ends
